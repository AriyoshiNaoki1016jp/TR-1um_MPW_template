** sch_path: /mnt/c/Users/naoki/opensusi/TR-1um_MPW_template/src/tr_1um_AriyoshiNaoki1016jp.sch
**.subckt tr_1um_AriyoshiNaoki1016jp P1 P2 P3 P4 P5 P6 P7 VSS VDD P15 P14 P13 P12 P11 P10 P9
*.iopin P1
*.iopin P2
*.iopin P3
*.iopin P4
*.iopin P5
*.iopin P6
*.iopin P7
*.iopin VSS
*.iopin VDD
*.iopin P15
*.iopin P14
*.iopin P13
*.iopin P12
*.iopin P11
*.iopin P10
*.iopin P9
x1 P1 VDD P2 P15 P14 P3 P4 P13 P5 P12 P6 P11 P10 P7 P9 VSS OSS_FRAME
XXM1 N1 P2 net1 VSS NMOS w=3.4u l=1u nrd=0 nrs=0
XXM3 N1 P3 VDD VDD PMOS w=3.4u l=1u nrd=0 nrs=0
XXM4 N1 P2 VDD VDD PMOS w=3.4u l=1u nrd=0 nrs=0
XXM2 net1 P3 VSS VSS NMOS w=3.4u l=1u nrd=0 nrs=0
XXM5 N2 N1 net2 VSS NMOS w=3.4u l=1u nrd=0 nrs=0
XXM6 N2 P3 VDD VDD PMOS w=3.4u l=1u nrd=0 nrs=0
XXM7 N2 N1 VDD VDD PMOS w=3.4u l=1u nrd=0 nrs=0
XXM8 net2 P3 VSS VSS NMOS w=3.4u l=1u nrd=0 nrs=0
XXM9 N3 N1 net3 VSS NMOS w=3.4u l=1u nrd=0 nrs=0
XXM10 N3 P2 VDD VDD PMOS w=3.4u l=1u nrd=0 nrs=0
XXM11 N3 N1 VDD VDD PMOS w=3.4u l=1u nrd=0 nrs=0
XXM12 net3 P2 VSS VSS NMOS w=3.4u l=1u nrd=0 nrs=0
XXM13 P N3 net4 VSS NMOS w=3.4u l=1u nrd=0 nrs=0
XXM14 P N2 VDD VDD PMOS w=3.4u l=1u nrd=0 nrs=0
XXM15 P N3 VDD VDD PMOS w=3.4u l=1u nrd=0 nrs=0
XXM16 net4 N2 VSS VSS NMOS w=3.4u l=1u nrd=0 nrs=0
XXM17 N5 N4 net5 VSS NMOS w=3.4u l=1u nrd=0 nrs=0
XXM18 N5 P VDD VDD PMOS w=3.4u l=1u nrd=0 nrs=0
XXM19 N5 N4 VDD VDD PMOS w=3.4u l=1u nrd=0 nrs=0
XXM20 net5 P VSS VSS NMOS w=3.4u l=1u nrd=0 nrs=0
XXM21 N4 P1 net6 VSS NMOS w=3.4u l=1u nrd=0 nrs=0
XXM22 N4 P VDD VDD PMOS w=3.4u l=1u nrd=0 nrs=0
XXM23 N4 P1 VDD VDD PMOS w=3.4u l=1u nrd=0 nrs=0
XXM24 net6 P VSS VSS NMOS w=3.4u l=1u nrd=0 nrs=0
XXM25 N6 N4 net7 VSS NMOS w=3.4u l=1u nrd=0 nrs=0
XXM26 N6 P1 VDD VDD PMOS w=3.4u l=1u nrd=0 nrs=0
XXM27 N6 N4 VDD VDD PMOS w=3.4u l=1u nrd=0 nrs=0
XXM28 net7 P1 VSS VSS NMOS w=3.4u l=1u nrd=0 nrs=0
XXM29 P13 N6 net8 VSS NMOS w=3.4u l=1u nrd=0 nrs=0
XXM30 P13 N5 VDD VDD PMOS w=3.4u l=1u nrd=0 nrs=0
XXM31 P13 N6 VDD VDD PMOS w=3.4u l=1u nrd=0 nrs=0
XXM32 net8 N5 VSS VSS NMOS w=3.4u l=1u nrd=0 nrs=0
XXM33 P12 N4 net9 VSS NMOS w=3.4u l=1u nrd=0 nrs=0
XXM34 P12 N1 VDD VDD PMOS w=3.4u l=1u nrd=0 nrs=0
XXM35 P12 N4 VDD VDD PMOS w=3.4u l=1u nrd=0 nrs=0
XXM36 net9 N1 VSS VSS NMOS w=3.4u l=1u nrd=0 nrs=0
XM1 Cout2 P12 VDD VDD PMOS w=10u l=1u nrd=0 nrs=0
XM2 Cout2 P12 VSS VSS NMOS w=5u l=1u nrd=0 nrs=0
XM3 P14 Cout2 VDD VDD PMOS w=20u l=1u nrd=0 nrs=0 m=2
XM4 P14 Cout2 VSS VSS NMOS w=10u l=1u nrd=0 nrs=0 m=2
XM5 S2 P13 VDD VDD PMOS w=10u l=1u nrd=0 nrs=0
XM6 S2 P13 VSS VSS NMOS w=5u l=1u nrd=0 nrs=0
XM7 P15 S2 VDD VDD PMOS w=20u l=1u nrd=0 nrs=0 m=2
XM8 P15 S2 VSS VSS NMOS w=10u l=1u nrd=0 nrs=0 m=2
XXM37 P6 P4 net10 VSS NMOS w=3.4u l=1u nrd=0 nrs=0
XXM38 P6 P5 VDD VDD PMOS w=3.4u l=1u nrd=0 nrs=0
XXM39 P6 P4 VDD VDD PMOS w=3.4u l=1u nrd=0 nrs=0
XXM40 net10 P5 VSS VSS NMOS w=3.4u l=1u nrd=0 nrs=0
XM9 P9 P7 VDD VDD PMOS w=10u l=1u nrd=0 nrs=0
XM10 P9 P7 VSS VSS NMOS w=5u l=1u nrd=0 nrs=0
XM11 P11 P10 VDD VDD PMOS w=20u l=1u nrd=0 nrs=0 m=2
XM12 P11 P10 VSS VSS NMOS w=10u l=1u nrd=0 nrs=0 m=2
**** begin user architecture code

.include /home/naoki/pdk/TR-1um/libs.tech/spice/models/ip62_models

**** end user architecture code
**.ends

* expanding   symbol:  OSS_FRAME.sym # of pins=16
** sym_path: /home/naoki/pdk/TR-1um/libs.tech/xschem/TR-1um_frame/OSS_FRAME.sym
** sch_path: /home/naoki/pdk/TR-1um/libs.tech/xschem/TR-1um_frame/OSS_FRAME.sch
.subckt OSS_FRAME P1 VDD P2 P15 P14 P3 P4 P13 P5 P12 P6 P11 P10 P7 P9 VSS
*.iopin P1
*.iopin P2
*.iopin P3
*.iopin P4
*.iopin P5
*.iopin P6
*.iopin P7
*.iopin VSS
*.iopin VDD
*.iopin P15
*.iopin P14
*.iopin P13
*.iopin P12
*.iopin P11
*.iopin P10
*.iopin P9
x1 VDD P1 VSS OSS_ESD_5V_ANA
x2 VDD VSS OSS_ESD_5V_VDD
x3 VDD VSS OSS_ESD_5V_VSS
x4 VDD P2 VSS OSS_ESD_5V_ANA
x5 VDD P3 VSS OSS_ESD_5V_ANA
x6 VDD P4 VSS OSS_ESD_5V_ANA
x7 VDD P5 VSS OSS_ESD_5V_ANA
x8 VDD P6 VSS OSS_ESD_5V_ANA
x9 VDD P7 VSS OSS_ESD_5V_ANA
x10 VDD P15 VSS OSS_ESD_5V_ANA
x11 VDD P14 VSS OSS_ESD_5V_ANA
x12 VDD P13 VSS OSS_ESD_5V_ANA
x13 VDD P12 VSS OSS_ESD_5V_ANA
x14 VDD P11 VSS OSS_ESD_5V_ANA
x15 VDD P10 VSS OSS_ESD_5V_ANA
x16 VDD P9 VSS OSS_ESD_5V_ANA
.ends

* expanding   symbol:  OSS_ESD_5V_ANA.sym # of pins=4
** sym_path: /home/naoki/pdk/TR-1um/libs.tech/xschem/TR-1um_frame/OSS_ESD_5V_ANA.sym
** sch_path: /home/naoki/pdk/TR-1um/libs.tech/xschem/TR-1um_frame/OSS_ESD_5V_ANA.sch
.subckt OSS_ESD_5V_ANA VDD PAD VSS
*.iopin PAD
*.iopin VDD
*.iopin VSS
XXM1 PAD VDD VDD VDD MPE w=500u l=2u as=0 ad=0 ps=0 pd=0 nrd=0 nrs=0
XXM2 PAD VSS VSS VSS MNE w=500u l=2u as=0 ad=0 ps=0 pd=0 nrd=0 nrs=0
.ends

* expanding   symbol:  OSS_ESD_5V_VDD.sym # of pins=3
** sym_path: /home/naoki/pdk/TR-1um/libs.tech/xschem/TR-1um_frame/OSS_ESD_5V_VDD.sym
** sch_path: /home/naoki/pdk/TR-1um/libs.tech/xschem/TR-1um_frame/OSS_ESD_5V_VDD.sch
.subckt OSS_ESD_5V_VDD VDD VSS
*.iopin VDD
*.iopin VSS
XXM1 VDD VDD VDD VDD MPE w=500u l=2u as=0 ad=0 ps=0 pd=0 nrd=0 nrs=0
XXM2 VDD VSS VSS VSS MNE w=500u l=2u as=0 ad=0 ps=0 pd=0 nrd=0 nrs=0
.ends

* expanding   symbol:  OSS_ESD_5V_VSS.sym # of pins=3
** sym_path: /home/naoki/pdk/TR-1um/libs.tech/xschem/TR-1um_frame/OSS_ESD_5V_VSS.sym
** sch_path: /home/naoki/pdk/TR-1um/libs.tech/xschem/TR-1um_frame/OSS_ESD_5V_VSS.sch
.subckt OSS_ESD_5V_VSS VDD VSS
*.iopin VSS
*.iopin VDD
XXM1 VSS VDD VDD VDD MPE w=500u l=2u as=0 ad=0 ps=0 pd=0 nrd=0 nrs=0
XXM2 VSS VSS VSS VSS MNE w=500u l=2u as=0 ad=0 ps=0 pd=0 nrd=0 nrs=0
.ends

.end
